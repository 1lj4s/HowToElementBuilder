`include "discipline.h"
`include "constants.h"

module TFR(pos, neg);
    inout pos, neg;
    electrical pos, neg;

    parameter real RS = 1.0 from (0:inf);
    parameter real L = 1e-6 from (0:inf);
    parameter real W = 1e-6 from (0:inf);
    parameter real vref = 1.0 from [0:inf);

    analog begin

        real res = (RS * L / W) * (1 + 0.01*(V(pos,neg) - vref));

        I(pos, neg) <+ V(pos, neg) / res;

    end
endmodule
