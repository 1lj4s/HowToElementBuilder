`include "constants.h"
`include "discipline.h"

module MOPEN(p, n);
    inout p, n;
    electrical p, n;

    parameter real W = 1000.0;
    parameter real H = 300.0;
    parameter real ER1 = 12.9;

    real W_um, H_um, WH_ratio, E_eff, DL_ex, Z0, COC;

    analog begin
        W_um = W * 1.e6;
        H_um = H * 1.e6;
        WH_ratio = W_um / H_um;

        E_eff = (ER1 + 1.0)/2.0 + (ER1 - 1.0)/2.0 / sqrt(1.0 + 12.0/WH_ratio);

        DL_ex = 0.412 * H_um * (E_eff + 0.3)/(E_eff - 0.258) * (WH_ratio + 0.264)/(WH_ratio + 0.8);

        if (WH_ratio <= 1.0) begin
            Z0 = 60.0/sqrt(E_eff) * ln(8.0/WH_ratio + 0.25*WH_ratio);
        end else begin
            Z0 = 120.0*`M_PI/(sqrt(E_eff) * (WH_ratio + 1.393 + 0.667*ln(WH_ratio + 1.444)));
        end

        COC = (DL_ex * 1e-6 * sqrt(E_eff))/(3e8 * Z0);

        I(p, n) <+ ddt(COC * V(p, n));
    end
endmodule
