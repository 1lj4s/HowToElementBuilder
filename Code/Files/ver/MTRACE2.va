`include "constants.h"
`include "discipline.h"

module MTRACE2(p1, p2);
    inout p1, p2;
    electrical p1, p2;

    parameter real ER1 = 12.9;    // Относительная диэлектрическая проницаемость
    parameter real H = 0.1e-3;   // Высота подложки [м]
    parameter real W = 0.2e-3;   // Ширина линии [м]
    parameter real length = 1e-6; // Длина линии [м] (1 мм)

    // Константы
    parameter real c_mps = 299792458; // Скорость света
    parameter real pi = 3.141592653589793; // Число π

    // Внутренние узлы
    electrical [0:12]node; // 13 узлов

    real wh_ratio, e_eff, Z0;
    real L_total, C_total, L_seg_SI, C_seg_SI;  // В Гн/м и Ф/м, затем в Гн и Ф на сегмент

    analog begin
        // Расчет отношения w/H
        wh_ratio = W / H;

        // Расчет эффективной диэлектрической проницаемости
        if (wh_ratio <= 1.0) begin
            e_eff = (ER1 + 1.0)/2.0 + (ER1 - 1.0)/2.0 * (
                    1.0 / sqrt(1.0 + 12.0/wh_ratio) + 0.04 * pow(1.0 - wh_ratio, 2.0) );
        end else begin
            e_eff = (ER1 + 1.0)/2.0 + (ER1 - 1.0)/2.0 * (
                    1.0 / sqrt(1.0 + 12.0/wh_ratio) );
        end

        // Расчет характеристического сопротивления
        if (wh_ratio <= 1.0) begin
            Z0 = (60.0 / sqrt(e_eff)) * ln(8.0/wh_ratio + 0.25*wh_ratio);
        end else begin
            Z0 = (120.0 * pi) / (sqrt(e_eff) * (wh_ratio + 1.393 + 0.667*ln(wh_ratio + 1.444)));
        end

        // Расчет погонных L и C (на метр)
        L_total = (Z0 * sqrt(e_eff)) / c_mps;  // Гн/м
        C_total = (sqrt(e_eff)) / (Z0 * c_mps); // Ф/м

        // Параметры для всей линии
        L_seg_SI = (L_total * length) / 12.0;
        C_seg_SI = (C_total * length) / 13.0;

        // Подключение портов
        V(p1, node[0]) <+ 0;
        V(p2, node[12]) <+ 0;

        // Индуктивные сегменты (12 элементов)
        V(node[0], node[1]) <+ L_seg_SI * ddt(I(node[0], node[1]));
        V(node[1], node[2]) <+ L_seg_SI * ddt(I(node[1], node[2]));
        V(node[2], node[3]) <+ L_seg_SI * ddt(I(node[2], node[3]));
        V(node[3], node[4]) <+ L_seg_SI * ddt(I(node[3], node[4]));
        V(node[4], node[5]) <+ L_seg_SI * ddt(I(node[4], node[5]));
        V(node[5], node[6]) <+ L_seg_SI * ddt(I(node[5], node[6]));
        V(node[6], node[7]) <+ L_seg_SI * ddt(I(node[6], node[7]));
        V(node[7], node[8]) <+ L_seg_SI * ddt(I(node[7], node[8]));
        V(node[8], node[9]) <+ L_seg_SI * ddt(I(node[8], node[9]));
        V(node[9], node[10]) <+ L_seg_SI * ddt(I(node[9], node[10]));
        V(node[10], node[11]) <+ L_seg_SI * ddt(I(node[10], node[11]));
        V(node[11], node[12]) <+ L_seg_SI * ddt(I(node[11], node[12]));

        // Емкостные сегменты (13 элементов)
        I(node[0]) <+ C_seg_SI * ddt(V(node[0]));
        I(node[1]) <+ C_seg_SI * ddt(V(node[1]));
        I(node[2]) <+ C_seg_SI * ddt(V(node[2]));
        I(node[3]) <+ C_seg_SI * ddt(V(node[3]));
        I(node[4]) <+ C_seg_SI * ddt(V(node[4]));
        I(node[5]) <+ C_seg_SI * ddt(V(node[5]));
        I(node[6]) <+ C_seg_SI * ddt(V(node[6]));
        I(node[7]) <+ C_seg_SI * ddt(V(node[7]));
        I(node[8]) <+ C_seg_SI * ddt(V(node[8]));
        I(node[9]) <+ C_seg_SI * ddt(V(node[9]));
        I(node[10]) <+ C_seg_SI * ddt(V(node[10]));
        I(node[11]) <+ C_seg_SI * ddt(V(node[11]));
        I(node[12]) <+ C_seg_SI * ddt(V(node[12]));
    end
endmodule
