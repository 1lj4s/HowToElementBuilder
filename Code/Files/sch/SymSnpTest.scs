simulator lang=local

global 0

NPORT0 1 0 2 0 nport file="D:\saves\Pycharm\HowToElementBuilder\Code\Files\snp\MXOVER_test.s4p"

PORT0 1 0 port r=50 num=1 type=sine rptstart=1 rpttimes=0
PORT1 2 0 port r=50 num=2 type=sine rptstart=1 rpttimes=0

SPSweep sp start=1 stop=20G step=10000 file="D:\saves\Pycharm\HowToElementBuilder\Code\Files\sym\SymSnpTest.s2p"

DEFAULT_OPTIONS options tnom=27 temp=27 reltol=1.000000e-03
