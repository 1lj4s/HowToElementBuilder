simulator lang=local

global 0

NPORT0 1 0 2 0 nport file="C:\Users\ZYS\PycharmProjects\HowToElementBuilder\Code\Files\snp\MLIN_test.s2p"

PORT0 1 0 port r=50 num=1 type=sine rptstart=1 rpttimes=0
PORT1 2 0 port r=50 num=2 type=sine rptstart=1 rpttimes=0

SPSweep sp start=0.1G stop=67G step=0.1G file="C:\Users\ZYS\PycharmProjects\HowToElementBuilder\Code\Files\sym\MLIN_test.s2p"

DEFAULT_OPTIONS options tnom=27 temp=27 reltol=1.000000e-03
