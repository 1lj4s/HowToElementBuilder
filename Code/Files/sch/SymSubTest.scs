simulator lang=local

global 0

include 'D:\saves\Pycharm\HowToElementBuilder\Code\Files\cir\MLIN_test.cir'

U1 p1 p2 s_equivalent

PORT1 p1 0 port r=50 num=1 type=sine fundname=aaa ampl=0.0001 freq=5000000000 data=0 rptstart=1 rpttimes=0 mag=1e-006
PORT2 p2 0 port r=50 num=2 type=sine fundname=aaa ampl=0.0001 freq=5000000000 data=0 rptstart=1 rpttimes=0 mag=1e-006

sp sp start=0.1G stop=67G dec=401 file="D:\saves\Pycharm\HowToElementBuilder\Code\Files\sym\MLIN_test.s2p"

DEFAULT_OPTIONS options tnom=27 temp=27  acout=0 fast_spice=0 reltol=1.000000e-003 rawfmt=nutascii
