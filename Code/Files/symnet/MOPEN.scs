simulator lang=local
global 0
include "D:\saves\Pycharm\HowToElementBuilder\Code\Files\sub\MOPEN.cir"
U1 p1 MOPEN T = 2e-06 H = 0.0001 ER0 = 1.0 MU0 = 1.0 TD0 = 0.0 ER1 = 12.9 MU1 = 1.0001 TD1 = 0.003 W = 7e-05 NumPorts = 1
PORT1 p1 0 port r=50 num=1 type=sine fundname=aaa ampl=0.0001 freq=5000000000 data=0 rptstart=1 rpttimes=0 mag=1e-006
SPSweep sp start=100000000 stop=67000000000 step=669000000.0 file="D:\saves\Pycharm\HowToElementBuilder\Code\Files\symout\MOPEN.s1p"
DEFAULT_OPTIONS options tnom=27 temp=27  acout=0 fast_spice=0 reltol=1.000000e-003 rawfmt=nutascii
