simulator lang=local
global 0
NPORT0 1 0 nport file="E:\Saves\pycharm\HowToElementBuilder\Code\Files\snp\MRSTUB2W.s1p"
PORT0 1 0 port r=50 num=1 type=sine rptstart=1 rpttimes=0
SPSweep sp start=100000000 stop=67000000000 step=669000000.0 file="E:\Saves\pycharm\HowToElementBuilder\Code\Files\symout\MRSTUB2W.s1p"
DEFAULT_OPTIONS options tnom=27 temp=27  acout=0 fast_spice=0 reltol=1.000000e-003 rawfmt=nutascii
