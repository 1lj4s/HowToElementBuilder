simulator lang=local
global 0

NPORT0 1 0 2 0 3 0 4 0 nport file="E:\Saves\pycharm\HowToElementBuilder\Code\Files\snp\MCLIN.s4p"
PORT0 1 0 port r=50 num=1 type=sine rptstart=1 rpttimes=0
PORT1 2 0 port r=50 num=2 type=sine rptstart=1 rpttimes=0
PORT2 3 0 port r=50 num=3 type=sine rptstart=1 rpttimes=0
PORT3 4 0 port r=50 num=4 type=sine rptstart=1 rpttimes=0

SPSweep sp start=100000000 stop=67000000000 step=669000000.0 file="E:\Saves\pycharm\HowToElementBuilder\Code\Files\symout\MCLIN.s4p"

DEFAULT_OPTIONS options tnom=27 temp=27  acout=0 fast_spice=0 reltol=1.000000e-003 rawfmt=nutascii
